;;-----------------------------------------------------------------------------
;; Bindkeys for 'Command Interpreter'
;;-----------------------------------------------------------------------------
hiSetBindKeys( "Command Interpreter" list(
    list("Ctrl<Key>L"   "ddsOpenLibManager()")
    list("Ctrl<Key>R"   "vvDisplayBrowser()")
)) ;; hiSetBindKeys
;;-----------------------------------------------------------------------------
