asiSetEnvOptionVal(asiGetTool('spectre) "modelFiles" list(
list("/process/hosted/tsmc/tsmcN65/oa/1p0c/1p9m_6X1Z1U_ALRDL_rf_mim2p0/tsmcN65/../models/spectre/crn65gplus_2d5_lk_v1d0.scs" "tt_bip")
list("/process/hosted/tsmc/tsmcN65/oa/1p0c/1p9m_6X1Z1U_ALRDL_rf_mim2p0/tsmcN65/../models/spectre/crn65gplus_2d5_lk_v1d0.scs" "tt_dio")
list("/process/hosted/tsmc/tsmcN65/oa/1p0c/1p9m_6X1Z1U_ALRDL_rf_mim2p0/tsmcN65/../models/spectre/crn65gplus_2d5_lk_v1d0.scs" "tt_dio_33")
list("/process/hosted/tsmc/tsmcN65/oa/1p0c/1p9m_6X1Z1U_ALRDL_rf_mim2p0/tsmcN65/../models/spectre/crn65gplus_2d5_lk_v1d0.scs" "VAR(\"rcc\")_mim")
list("/process/hosted/tsmc/tsmcN65/oa/1p0c/1p9m_6X1Z1U_ALRDL_rf_mim2p0/tsmcN65/../models/spectre/crn65gplus_2d5_lk_v1d0.scs" "tt_dio_dnw")
list("/process/hosted/tsmc/tsmcN65/oa/1p0c/1p9m_6X1Z1U_ALRDL_rf_mim2p0/tsmcN65/../models/spectre/crn65gplus_2d5_lk_v1d0.scs" "tt_dio_18")
list("/process/hosted/tsmc/tsmcN65/oa/1p0c/1p9m_6X1Z1U_ALRDL_rf_mim2p0/tsmcN65/../models/spectre/crn65gplus_2d5_lk_v1d0.scs" "tt_bip_npn")
list("/process/hosted/tsmc/tsmcN65/oa/1p0c/1p9m_6X1Z1U_ALRDL_rf_mim2p0/tsmcN65/../models/spectre/crn65gplus_2d5_lk_v1d0.scs" "VAR(\"pc\")_33")
list("/process/hosted/tsmc/tsmcN65/oa/1p0c/1p9m_6X1Z1U_ALRDL_rf_mim2p0/tsmcN65/../models/spectre/crn65gplus_2d5_lk_v1d0.scs" "tt_rfrtmom")
list("/process/hosted/tsmc/tsmcN65/oa/1p0c/1p9m_6X1Z1U_ALRDL_rf_mim2p0/tsmcN65/../models/spectre/crn65gplus_2d5_lk_v1d0.scs" "VAR(\"rcc\")_mos_cap_25")
list("/process/hosted/tsmc/tsmcN65/oa/1p0c/1p9m_6X1Z1U_ALRDL_rf_mim2p0/tsmcN65/../models/spectre/crn65gplus_2d5_lk_v1d0.scs" "tt_18")
list("/process/hosted/tsmc/tsmcN65/oa/1p0c/1p9m_6X1Z1U_ALRDL_rf_mim2p0/tsmcN65/../models/spectre/crn65gplus_2d5_lk_v1d0.scs" "tt_disres")
list("/process/hosted/tsmc/tsmcN65/oa/1p0c/1p9m_6X1Z1U_ALRDL_rf_mim2p0/tsmcN65/../models/spectre/crn65gplus_2d5_lk_v1d0.scs" "VAR(\"rcc\")_res")
list("/process/hosted/tsmc/tsmcN65/oa/1p0c/1p9m_6X1Z1U_ALRDL_rf_mim2p0/tsmcN65/../models/spectre/crn65gplus_2d5_lk_v1d0.scs" "tt_dio_na")
list("/process/hosted/tsmc/tsmcN65/oa/1p0c/1p9m_6X1Z1U_ALRDL_rf_mim2p0/tsmcN65/../models/spectre/crn65gplus_2d5_lk_v1d0.scs" "VAR(\"pc\")_rfmos_33")
list("/process/hosted/tsmc/tsmcN65/oa/1p0c/1p9m_6X1Z1U_ALRDL_rf_mim2p0/tsmcN65/../models/spectre/crn65gplus_2d5_lk_v1d0.scs" "tt_dio_hvt")
list("/process/hosted/tsmc/tsmcN65/oa/1p0c/1p9m_6X1Z1U_ALRDL_rf_mim2p0/tsmcN65/../models/spectre/crn65gplus_2d5_lk_v1d0.scs" "VAR(\"rcc\")_rfmvar")
list("/process/hosted/tsmc/tsmcN65/oa/1p0c/1p9m_6X1Z1U_ALRDL_rf_mim2p0/tsmcN65/../models/spectre/crn65gplus_2d5_lk_v1d0.scs" "tt_rfmos_18")
list("/process/hosted/tsmc/tsmcN65/oa/1p0c/1p9m_6X1Z1U_ALRDL_rf_mim2p0/tsmcN65/../models/spectre/crn65gplus_2d5_lk_v1d0.scs" "VAR(\"pc\")_na")
list("/process/hosted/tsmc/tsmcN65/oa/1p0c/1p9m_6X1Z1U_ALRDL_rf_mim2p0/tsmcN65/../models/spectre/crn65gplus_2d5_lk_v1d0.scs" "tt_dio_na33")
list("/process/hosted/tsmc/tsmcN65/oa/1p0c/1p9m_6X1Z1U_ALRDL_rf_mim2p0/tsmcN65/../models/spectre/crn65gplus_2d5_lk_v1d0.scs" "tt_dio_lvt")
list("/process/hosted/tsmc/tsmcN65/oa/1p0c/1p9m_6X1Z1U_ALRDL_rf_mim2p0/tsmcN65/../models/spectre/crn65gplus_2d5_lk_v1d0.scs" "tt_rfres_sa")
list("/process/hosted/tsmc/tsmcN65/oa/1p0c/1p9m_6X1Z1U_ALRDL_rf_mim2p0/tsmcN65/../models/spectre/crn65gplus_2d5_lk_v1d0.scs" "tt_na33")
list("/process/hosted/tsmc/tsmcN65/oa/1p0c/1p9m_6X1Z1U_ALRDL_rf_mim2p0/tsmcN65/../models/spectre/crn65gplus_2d5_lk_v1d0.scs" "tt_dio_esd")
list("/process/hosted/tsmc/tsmcN65/oa/1p0c/1p9m_6X1Z1U_ALRDL_rf_mim2p0/tsmcN65/../models/spectre/crn65gplus_2d5_lk_v1d0.scs" "VAR(\"rcc\")_rfmim")
list("/process/hosted/tsmc/tsmcN65/oa/1p0c/1p9m_6X1Z1U_ALRDL_rf_mim2p0/tsmcN65/../models/spectre/crn65gplus_2d5_lk_v1d0.scs" "tt_dio_25od33")
list("/process/hosted/tsmc/tsmcN65/oa/1p0c/1p9m_6X1Z1U_ALRDL_rf_mim2p0/tsmcN65/../models/spectre/crn65gplus_2d5_lk_v1d0.scs" "VAR(\"pc\")_25od33")
list("/process/hosted/tsmc/tsmcN65/oa/1p0c/1p9m_6X1Z1U_ALRDL_rf_mim2p0/tsmcN65/../models/spectre/crn65gplus_2d5_lk_v1d0.scs" "VAR(\"pc\")")
list("/process/hosted/tsmc/tsmcN65/oa/1p0c/1p9m_6X1Z1U_ALRDL_rf_mim2p0/tsmcN65/../models/spectre/crn65gplus_2d5_lk_v1d0.scs" "VAR(\"rcc\")_mos_cap")
list("/process/hosted/tsmc/tsmcN65/oa/1p0c/1p9m_6X1Z1U_ALRDL_rf_mim2p0/tsmcN65/../models/spectre/crn65gplus_2d5_lk_v1d0.scs" "tt_dio_25")
list("/process/hosted/tsmc/tsmcN65/oa/1p0c/1p9m_6X1Z1U_ALRDL_rf_mim2p0/tsmcN65/../models/spectre/crn65gplus_2d5_lk_v1d0.scs" "tt_dio_25ud18")
list("/process/hosted/tsmc/tsmcN65/oa/1p0c/1p9m_6X1Z1U_ALRDL_rf_mim2p0/tsmcN65/../models/spectre/crn65gplus_2d5_lk_v1d0.scs" "VAR(\"pc\")_25")
list("/process/hosted/tsmc/tsmcN65/oa/1p0c/1p9m_6X1Z1U_ALRDL_rf_mim2p0/tsmcN65/../models/spectre/crn65gplus_2d5_lk_v1d0.scs" "VAR(\"pc\")_rfmos")
list("/process/hosted/tsmc/tsmcN65/oa/1p0c/1p9m_6X1Z1U_ALRDL_rf_mim2p0/tsmcN65/../models/spectre/crn65gplus_2d5_lk_v1d0.scs" "tt_25ud18")
list("/process/hosted/tsmc/tsmcN65/oa/1p0c/1p9m_6X1Z1U_ALRDL_rf_mim2p0/tsmcN65/../models/spectre/crn65gplus_2d5_lk_v1d0.scs" "tt_dio_na25od33")
list("/process/hosted/tsmc/tsmcN65/oa/1p0c/1p9m_6X1Z1U_ALRDL_rf_mim2p0/tsmcN65/../models/spectre/crn65gplus_2d5_lk_v1d0.scs" "tt_rfjvar")
list("/process/hosted/tsmc/tsmcN65/oa/1p0c/1p9m_6X1Z1U_ALRDL_rf_mim2p0/tsmcN65/../models/spectre/crn65gplus_2d5_lk_v1d0.scs" "VAR(\"pc\")_rfmos_25")
list("/process/hosted/tsmc/tsmcN65/oa/1p0c/1p9m_6X1Z1U_ALRDL_rf_mim2p0/tsmcN65/../models/spectre/crn65gplus_2d5_lk_v1d0.scs" "tt_rtmom")
list("/process/hosted/tsmc/tsmcN65/oa/1p0c/1p9m_6X1Z1U_ALRDL_rf_mim2p0/tsmcN65/../models/spectre/crn65gplus_2d5_lk_v1d0.scs" "tt_na25od33")
list("/process/hosted/tsmc/tsmcN65/oa/1p0c/1p9m_6X1Z1U_ALRDL_rf_mim2p0/tsmcN65/../models/spectre/crn65gplus_2d5_lk_v1d0.scs" "tt_dio_na25")
list("/process/hosted/tsmc/tsmcN65/oa/1p0c/1p9m_6X1Z1U_ALRDL_rf_mim2p0/tsmcN65/../models/spectre/crn65gplus_2d5_lk_v1d0.scs" "VAR(\"rcc\")_rfres_rpo")
list("/process/hosted/tsmc/tsmcN65/oa/1p0c/1p9m_6X1Z1U_ALRDL_rf_mim2p0/tsmcN65/../models/spectre/crn65gplus_2d5_lk_v1d0.scs" "VAR(\"pc\")_hvt")
list("/process/hosted/tsmc/tsmcN65/oa/1p0c/1p9m_6X1Z1U_ALRDL_rf_mim2p0/tsmcN65/../models/spectre/crn65gplus_2d5_lk_v1d0.scs" "tt_rfind")
list("/process/hosted/tsmc/tsmcN65/oa/1p0c/1p9m_6X1Z1U_ALRDL_rf_mim2p0/tsmcN65/../models/spectre/crn65gplus_2d5_lk_v1d0.scs" "VAR(\"rcc\")_rfmvar_25")
list("/process/hosted/tsmc/tsmcN65/oa/1p0c/1p9m_6X1Z1U_ALRDL_rf_mim2p0/tsmcN65/../models/spectre/crn65gplus_2d5_lk_v1d0.scs" "tt_na25")
list("/process/hosted/tsmc/tsmcN65/oa/1p0c/1p9m_6X1Z1U_ALRDL_rf_mim2p0/tsmcN65/../models/spectre/crn65gplus_2d5_lk_v1d0.scs" "VAR(\"pc\")_lvt")
list("/process/hosted/tsmc/tsmcN65/oa/1p0c/1p9m_6X1Z1U_ALRDL_rf_mim2p0/tsmcN65/../models/spectre/crn65gplus_2d5_lk_v1d0.scs" "stat_mis")
list("/process/hosted/tsmc/tsmcN65/oa/1p0c/1p9m_6X1Z1U_ALRDL_rf_mim2p0/tsmcN65/../models/spectre/crn65gplus_2d5_lk_v1d0.scs" "stat_mis_lvt")
list("/process/hosted/tsmc/tsmcN65/oa/1p0c/1p9m_6X1Z1U_ALRDL_rf_mim2p0/tsmcN65/../models/spectre/crn65gplus_2d5_lk_v1d0.scs" "stat_mis_hvt")
list("/process/hosted/tsmc/tsmcN65/oa/1p0c/1p9m_6X1Z1U_ALRDL_rf_mim2p0/tsmcN65/../models/spectre/crn65gplus_2d5_lk_v1d0.scs" "stat_mis_25")
list("/process/hosted/tsmc/tsmcN65/oa/1p0c/1p9m_6X1Z1U_ALRDL_rf_mim2p0/tsmcN65/../models/spectre/crn65gplus_2d5_lk_v1d0.scs" "stat_mis_na")
list("/process/hosted/tsmc/tsmcN65/oa/1p0c/1p9m_6X1Z1U_ALRDL_rf_mim2p0/tsmcN65/../models/spectre/crn65gplus_2d5_lk_v1d0.scs" "stat_mis_mim")
list("/process/hosted/tsmc/tsmcN65/oa/1p0c/1p9m_6X1Z1U_ALRDL_rf_mim2p0/tsmcN65/../models/spectre/crn65gplus_2d5_lk_v1d0.scs" "stat_mis_res")
list("/process/hosted/tsmc/tsmcN65/oa/1p0c/1p9m_6X1Z1U_ALRDL_rf_mim2p0/tsmcN65/../models/spectre/crn65gplus_2d5_lk_v1d0.scs" "stat_mis_disres")
list("/process/hosted/tsmc/tsmcN65/oa/1p0c/1p9m_6X1Z1U_ALRDL_rf_mim2p0/tsmcN65/../models/spectre/crn65gplus_2d5_lk_v1d0.scs" "stat_mis_33")
list("/process/hosted/tsmc/tsmcN65/oa/1p0c/1p9m_6X1Z1U_ALRDL_rf_mim2p0/tsmcN65/../models/spectre/crn65gplus_2d5_lk_v1d0.scs" "stat_mis_bip")
))
