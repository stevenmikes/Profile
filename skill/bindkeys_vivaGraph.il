;;-----------------------------------------------------------------------------
;; Bindkeys for 'vivaGraph'
;;-----------------------------------------------------------------------------
hiSetBindKeys( "vivaGraph" list(
    list("<Key>A"	"_ddtExecuteAction(awvGetCurrentWindow()->vivaSession \"aMarker\")")
    list("<Key>B"	"_ddtExecuteAction(awvGetCurrentWindow()->vivaSession \"bMarker\")")
    list("<Key>C"	"_vivaToggleTrackingCursor()")
    list("<Key>D"	"_ddtExecuteAction(awvGetCurrentWindow()->vivaSession \"addMarkerCreateDelta\")")
    list("<Key>DOWN"	"_ddtExecuteAction(awvGetCurrentWindow()->vivaSession \"panDown\")")
    list("<Key>Delete"	"_ddtExecuteAction(awvGetCurrentWindow()->vivaSession \"deleteObjects\")")
    list("<Key>E"	"_vivaDeleteAll()")
    list("<Key>F"	"_ddtExecuteAction(awvGetCurrentWindow()->vivaSession \"fitView\")")
    list("<Key>F11"	"deToggleAssistants()")
    list("<Key>G"	"_vivaToggleMinorGrids()")
    list("<Key>H"	"_ddtExecuteAction(awvGetCurrentWindow()->vivaSession \"horizontalMarker\")")
    list("<Key>LEFT"	"_ddtExecuteAction(awvGetCurrentWindow()->vivaSession \"panLeft\")")
    list("<Key>M"	"_ddtExecuteAction(awvGetCurrentWindow()->vivaSession \"pointMarker\")")
    list("<Key>N"	"_ddtExecuteAction(awvGetCurrentWindow()->vivaSession \"nextEdge\")")
    list("<Key>P"	"_ddtExecuteAction(awvGetCurrentWindow()->vivaSession \"prevEdge\")")
    list("<Key>Q"	"_ddtExecuteAction(awvGetCurrentWindow()->vivaSession \"editAttributes\")")
    list("<Key>R"	"_ddtExecuteAction(awvGetCurrentWindow()->vivaSession \"refPointMarker\")")
    list("<Key>RIGHT"	"_ddtExecuteAction(awvGetCurrentWindow()->vivaSession \"panRight\")")
    list("<Key>T"	"_ddtExecuteAction(awvGetCurrentWindow()->vivaSession \"transEdgeMarker\")")
    list("<Key>U"	"_ddtExecuteAction(awvGetCurrentWindow()->vivaSession \"undo\")")
    list("<Key>UP"	"_ddtExecuteAction(awvGetCurrentWindow()->vivaSession \"panUp\")")
    list("<Key>V"	"_ddtExecuteAction(awvGetCurrentWindow()->vivaSession \"verticalMarker\")")
    list("<Key>X"	"_ddtExecuteAction(awvGetCurrentWindow()->vivaSession \"zoomModeX\")")
    list("<Key>Y"	"_ddtExecuteAction(awvGetCurrentWindow()->vivaSession \"zoomModeY\")")
    list("<Key>Z"	"_ddtExecuteAction(awvGetCurrentWindow()->vivaSession \"zoomModeXY\")")
    list("<Key>["	"_ddtExecuteAction(awvGetCurrentWindow()->vivaSession \"zoomOut\")")
    list("<Key>]"	"_ddtExecuteAction(awvGetCurrentWindow()->vivaSession \"zoomIn\")")
    list("<Key>," "vivaPrevGraphWindow()")
    list("<Key>." "vivaNextGraphWindow()")
    list("Ctrl<Key>A"	"_ddtExecuteAction(awvGetCurrentWindow()->vivaSession \"selectAllTracesInStrip\")")
    list("Ctrl<Key>E"	"_vivaDeleteAllMarkers()")
    list("Ctrl<Key>F"	"_ddtExecuteAction(awvGetCurrentWindow()->vivaSession \"fitTrace\")")
    list("Ctrl<Key>L"	"_ddtExecuteAction(awvGetCurrentWindow()->vivaSession \"graphLoadState\")")
    list("Ctrl<Key>N"	"awvCreatePlotWindow()")
    list("Ctrl<Key>Q"	"_vvCloseAllWindows(awvGetCurrentWindow()->vivaSession)")
    list("Ctrl<Key>R"	"_ddtUpdateGraph(awvGetCurrentWindow()->vivaSession _vivaMapSubwinId(awvGetCurrentWindow()->vivaSession awvGetCurrentWindow() awvGetCurrentSubwindow(awvGetCurrentWindow())) nil nil)")
    list("Ctrl<Key>S"	"_ddtExecuteAction(awvGetCurrentWindow()->vivaSession \"graphSaveState\")")
    list("Ctrl<Key>V"	"_ddtExecuteAction(awvGetCurrentWindow()->vivaSession \"paste\")")
    list("Ctrl<Key>X"	"_ddtExecuteAction(awvGetCurrentWindow()->vivaSession \"cut\")")
    list("Shift<Key>C"	"_ddtExecuteAction(awvGetCurrentWindow()->vivaSession \"copy\")")
    list("Shift<Key>D"	"_ddtExecuteAction(awvGetCurrentWindow()->vivaSession \"createDeltaMarker\")")
    list("Shift<Key>E"	"_vivaDeleteAllTraces()")
    list("Shift<Key>F"	"_ddtExecuteAction(awvGetCurrentWindow()->vivaSession \"fitSmith\")")
    list("Shift<Key>G"	"_vivaToggleMajorGrids()")
    list("Shift<Key>Q"	"_ddtExecuteAction(awvGetCurrentWindow()->vivaSession \"editGraphProperties\")")
    list("Shift<Key>U"	"_ddtExecuteAction(awvGetCurrentWindow()->vivaSession \"redo\")")
    list("ShiftCtrl<Key>A"	"_ddtExecuteAction(awvGetCurrentWindow()->vivaSession \"selectAllTraces\")")
)) ;; hiSetBindKeys
;;-----------------------------------------------------------------------------
