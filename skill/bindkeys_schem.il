;;-----------------------------------------------------------------------------
;; Bindkeys for 'Schematics'
;; Inherited by:
;;             * Diva
;;             * Hman-Schematic
;;             * NC-Verilog
;;             * Other-Schematic
;;             * Schematics XL
;;             * Simulation
;;             * Spectre-Schematic
;;             * UltraSim-Schematic
;;             * VHDL Toolbox
;;             * adegxl-schematic
;;             * adexl-schematic
;;             * analogArtist-Schematic
;;             * parasitics-Schematic
;;             * sip-schematic-packaging
;;             * sip-schematic-testbench
;;-----------------------------------------------------------------------------
hiSetBindKeys( "Schematics" list(
    list("<DrawThru1>"	"schDirectEdit(1)"	"geSingleSelectBox()")
    list("<DrawThru3>"	"hiZoomIn()"	"hiZoomIn()")
    list("<Key>'"	"hiUpdateMagOptions()")
    list("<Key>,"	""	"schSetEnv(\"sideways\" t)")
    list("<Key>."	""	"schSetEnv(\"upsideDown\" t)")
    list("<Key>5"	"schHiRouteFlightLine()"	"schHiRouteFlightLine()")
    list("<Key>8"	"schHiHiliteLabel(\"instance\" \"on\")"	"schHiHiliteLabel(\"instance\" \"on\")")
    list("<Key>9"	"geEnterAddNetProbe()"	"geEnterAddNetProbe()")
    list("<Key>="	"schHiOpenSymbolOrSchematicView(geGetEditCellView() hiGetCurrentWindow())"	"schHiOpenSymbolOrSchematicView(geGetEditCellView() hiGetCurrentWindow())")
    list("<Key>A"	"geSingleSelectPoint()"	"geSingleSelectPoint()")
    list("<Key>B"	"schHiCreateBlockInst()"	"schHiCreateBlockInst()")
    list("<Key>BackSpace"	"schHiDelete()"	"deletePoint()")
    list("<Key>C"	"schHiCopy()"	"schHiCopy()")
    list("<Key>D"	"geSubSelectPoint()"	"geSubSelectPoint()")
    list("<Key>Delete"	"schHiDelete()"	"schHiDelete()")
    list("<Key>Down"	"geScroll(nil \"s\" nil)"	"geScroll(nil \"s\" nil)")
    list("<Key>E"	"schHiDescendRead()"	"schHiDescendRead()")
    list("<Key>Escape"	""	"cancelEnterFun()")
    list("<Key>F"	"schZoomFit(1.0 0.9)"	"schZoomFit(1.0 0.9)")
    list("<Key>F1"	"hiHelp('window deGetAppInfo(deGetEditViewType(hiGetCurrentWindow()))->appName)"	"hiHelp('window deGetAppInfo(deGetEditViewType(hiGetCurrentWindow()))->appName)")
    list("<Key>F3"	""	"hiToggleEnterForm()")
    list("<Key>F4"	"geTogglePartialSelect()"	"geTogglePartialSelect()")
    list("<Key>F5"	"sevNetlistFile(sevSession(hiGetCurrentWindow()) `recreate)")
    list("<Key>F6"	"(sevRunEngine sevSession(hiGetCurrentWindow()))")
    list("<Key>F7"	"sevDirectPlot(sevSession(hiGetCurrentWindow()) `asiDirectPlotResultsMenuCB)")
    list("<Key>F8"	"sevDirectPlot(sevSession(hiGetCurrentWindow()) `asiiPlotACMagAndPhaseCB)")
    list("<Key>F9"	"sevDirectPlot(sevSession(hiGetCurrentWindow()) `asiiPlotTranSignalCB)")
    list("<Key>F10"	"sevDirectPlot(sevSession(hiGetCurrentWindow()) `asiiPlotTranSubtractCB)")
    list("<Key>F11"	"_mspsPointToPointCB()")
    ;list("<Key>F11"	"deToggleAssistants()"	"deToggleAssistants()")
    list("<Key>G"	"schHiFindMarker()"	"schHiFindMarker()")
    list("<Key>H"	"schHiHiliteLabel(\"wire\" \"on\")"	"schHiHiliteLabel(\"wire\" \"on\")")
    list("<Key>I"	"schHiCreateInst()"	"schHiCreateInst()")
    list("<Key>KP_0"	"sevAnnotateResults(sevSession(hiGetCurrentWindow()) 'defaults)")
    list("<Key>KP_1"	"sevAnnotateResults(sevSession(hiGetCurrentWindow()) 'dcNodeVoltages)")
    list("<Key>KP_2"	"sevAnnotateResults(sevSession(hiGetCurrentWindow()) 'dcOpPoints)")
    list("<Key>KP_3"	"showLabels()")
    list("<Key>KP_4"	"sevAnnotateResults(sevSession(hiGetCurrentWindow()) 'modelParameters)")
    list("<Key>KP_5"	"sevAnnotateResults(sevSession(hiGetCurrentWindow()) 'dcTermCurrents)")
    list("<Key>KP_6"	"hideLabels()")
    list("<Key>L"	"schHiCreateWireLabel()"	"schHiCreateWireLabel()")
    list("<Key>Left"	"geScroll(nil \"w\" nil)"	"geScroll(nil \"w\" nil)")
    list("<Key>M"	"schHiMove()"	"schHiMove()")
    list("<Key>N"	"schHiCreateNoteShape()"	"schHiCreateNoteShape()")
    list("<Key>O"	"schHiDisplayOptions()"	"schHiDisplayOptions()")
    list("<Key>P"	"schHiCreatePin()"	"schHiCreatePin()")
    list("<Key>Q"	"schHiObjectProperty()"	"schHiObjectProperty()")
    list("<Key>R"	"schHiRotate(t)"	"schSetEnv(\"rotate\" t)")
    list("<Key>Right"	"geScroll(nil \"e\" nil)"	"geScroll(nil \"e\" nil)")
    list("<Key>S"	"schHiStretch()"	"schSnapToConn()")
    list("<Key>T"	"schHiEditText()"	"schHiEditText()")
    list("<Key>U"	"hiUndo()"	"hiUndo()")
    list("<Key>Up"	"geScroll(nil \"n\" nil)"	"geScroll(nil \"n\" nil)")
    list("<Key>V"	"hiVectorPan()"	"hiVectorPan()")
    list("<Key>W"	"schHiCreateWire(0.0 \"route\" \"full\")" "schHiCreateWire(0.0 \"route\" \"full\")")
    list("<Key>X"	"schHiCheck(\"run\")"	"schHiCheck(\"run\")")
    list("<Key>Z"	"hiZoomIn()"	"hiZoomIn()")
    list("<Key>["	"hiZoomRelativeScale(getCurrentWindow() 0.5)"	"hiZoomRelativeScale(getCurrentWindow() 0.5)")
    list("<Key>]"	"hiZoomRelativeScale(getCurrentWindow() 1.5)"	"hiZoomRelativeScale(getCurrentWindow() 1.5)")
    list("<Key>`"	"hiZoomRelativeScale(getCurrentWindow() 0.5)"	"hiZoomRelativeScale(getCurrentWindow() 0.5)")
    list("<Key>space"	"schHiCreateWireStubs()")
    list("Ctrl Shift<Btn1Down>"	"hiZoomInMagnifier(hiGetCurrentWindow())")
    list("Ctrl Shift<Btn2Down>"	"hiZoomOutMagnifier(hiGetCurrentWindow())")
    list("Ctrl Shift<Btn4Down>"	"hiScaleMagnifier(1.25)")
    list("Ctrl Shift<Btn5Down>"	"hiScaleMagnifier(0.80)")
    list("Ctrl Shift<Key>Down"	"hiScaleMagnifier(0.80)")
    list("Ctrl Shift<Key>Up"	"hiScaleMagnifier(1.25)")
    list("Ctrl Shift<Key>Z"	"hiNextWinView(hiGetCurrentWindow())"	"hiNextWinView(hiGetCurrentWindow())")
    list("Ctrl Shift<Key>S"	"schHiViewToView()"	"schHiViewToView()")
    list("Ctrl<Btn1Down>"	"mouseSubSelectPt()"	"mouseSubSelectPt()")
    list("None<Btn4Down>"	"hiZoomInAtMouse()"	"hiZoomInAtMouse()")
    list("None<Btn5Down>"	"hiZoomOutAtMouse()"	"hiZoomOutAtMouse()")
    list("Ctrl<DrawThru1>"	"schDirectEdit(3)"	"geSubSelectBox()")
    list("Ctrl<Key>A"	"schSelectAllFig()"	"schSelectAllFig()")
    list("Ctrl<Key>D"	"schDeselectAllFig()"	"schDeselectAllFig()")
    list("Ctrl<Key>E"	"schHiReturn()"	"schHiReturn()")
    list("Ctrl<Key>F"	"schSetSelectOptions()"	"schSetSelectOptions()")
    list("Ctrl<Key>F11"	"deToggleToolbars()")
    list("Ctrl<Key>G"	"geHiDeleteMarker()"	"geHiDeleteMarker()")
    list("Ctrl<Key>R"	""	"schSetEnv(\"upsideDown\" t)")
    list("Ctrl<Key>S"	"_schHiSaveAs()"	"_schHiSaveAs()")
    list("Ctrl<Key>T"	"schHiZoomToSelSet()"	"schHiZoomToSelSet()")
    list("Ctrl<Key>Tab"	"hiLowerWindow(hiGetCurrentWindow())"	"hiLowerWindow(hiGetCurrentWindow())")
    list("Ctrl<Key>V"	"hiFocusToCIW(hiGetCurrentWindow())"	"hiFocusToCIW(hiGetCurrentWindow())")
    list("Ctrl<Key>W"	"CCScloseWindow()")
    list("Ctrl<Key>Z"	"hiZoomOut()"	"hiZoomOut()")
    list("Ctrl<key>b"	"VCADcvBrowseNotesUI()")
    list("Ctrl<key>h"	"VCADviewSelectedNoteUI()")
    list("Ctrl<key>n"	"VCADcvAddNoteRefUI()")
    list("Ctrl<key>O"	"sevChangeOutsOnSchematic(sevSession(hiGetCurrentWindow()) 'save)" )
    list("None<Btn1Down>"	"schSingleSelectPt()"	"mouseAddPt(t)")
    list("None<Btn1Down>(2)"	"schHiDefaultAction()"	"schMouseApplyOrFinish()")
    list("None<Btn2Down>"	"hiRepeat()"	"schCmdOption()")
    list("None<Btn3Down>"	"schHiMousePopUp()"	"schHiMousePopUp()")
    list("None<Btn3Down>(2)"	""	"hiToggleEnterForm()")
    list("Ctrl<Btn4Down>"	"geScroll(nil \"n\" nil)"	"geScroll(nil \"n\" nil)")
    list("Ctrl<Btn5Down>"	"geScroll(nil \"s\" nil)"	"geScroll(nil \"s\" nil)")
    list("Shift<Btn1Down>"	"schAddSelectPt()"	"mouseAddSelectPt()")
    list("Shift<Btn1Down>(2)"	"schExtendSelectPt()"	"schExtendSelectPt()")
    list("Shift<Btn2Down>"	""	"schShiftCmdOption()")
    list("Shift<Btn4Down>"	"geScroll(nil \"w\" nil)"	"geScroll(nil \"w\" nil)")
    list("Shift<Btn5Down>"	"geScroll(nil \"e\" nil)"	"geScroll(nil \"e\" nil)")
    list("Shift<DrawThru1>"	"schDirectEdit(2)"	"geAddSelectBox()")
    list("Shift<DrawThru3>"	"hiZoomOut()"	"hiZoomOut()")
    list("Shift<Key>8"	"schHiHiliteLabel(\"instance\" \"off\")"	"schHiHiliteLabel(\"instance\" \"off\")")
    list("Shift<Key>A"	"schSingleSelectBox()"	"schSingleSelectBox()")
    list("Shift<Key>D"	"schSubSelectBox()"	"schSubSelectBox()")
    list("Shift<Key>E"	"schHiDescendEdit()"	"schHiDescendEdit()")
    list("Shift<Key>F"	"hiZoomAbsoluteScale(getCurrentWindow() 0.9)"	"hiZoomAbsoluteScale(getCurrentWindow() 0.9)")
    list("Shift<Key>F11"	"deToggleAssistants() deToggleToolbars()")
    list("Shift<Key>F4"	"geToggleAreaSelectOption()"	"geToggleAreaSelectOption()")
    list("Shift<Key>G"	"schHiFindMarker()"	"schHiFindMarker()")
    list("Shift<Key>H"	"schHiHiliteLabel(\"wire\" \"off\")"	"schHiHiliteLabel(\"wire\" \"off\")")
    list("Shift<Key>L"	"schHiCreateNoteLabel()"	"schHiCreateNoteLabel()")
    list("Shift<Key>M"	"schHiMove()"	"schHiMove()")
    list("Shift<Key>N"	"schHiCreateNoteLabel()"	"schHiCreateNoteLabel()")
    list("Shift<Key>O"	"schHiEditorOptions()"	"schHiEditorOptions()")
    list("Shift<Key>Q"	"schHiCellViewProperty()"	"schHiCellViewProperty()")
    list("Shift<Key>R"	""	"schSetEnv(\"sideways\" t)")
    list("Shift<Key>S"	"schHiFind()"	"schHiFind()")
    list("Shift<Key>T"	"schHiTree()")
    list("Shift<Key>U"	"hiRedo()"	"hiRedo()")
    list("Shift<Key>V"	"_deToggleAssistant(\"World View\")"	"_deToggleAssistant(\"World View\")")
    ;;list("Shift<Key>W"	"schHiCreateWire(schGetEnv(\"defWideWireWidth\"))"	"schHiCreateWire(schGetEnv(\"defWideWireWidth\"))")
    list("Shift<Key>W"	"schHiCreateWire(0.0 \"route\" \"direct\")" "schHiCreateWire(0.0 \"route\" \"direct\")")
    list("Shift<Key>X"	"schHiCheckAndSave()"	"schHiCheckAndSave()")
    list("Shift<Key>Z"	"hiPrevWinView(hiGetCurrentWindow())"	"hiPrevWinView(hiGetCurrentWindow())")

    ;; Empty bindkeys (typically inserted when a bindkey is redefined or deleted)
)) ;; hiSetBindKeys
;;-----------------------------------------------------------------------------
