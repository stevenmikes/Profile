;;-----------------------------------------------------------------------------
;; Bindkeys for 'Layout'
;; Inherited by:
;;    * Dracula Interactive
;;    * High Capacity Power IR/EM
;;    * Hman-Layout
;;    * Hman-Symbolic
;;    * NC-Verilog-MaskLayout
;;    * Other-Layout
;;    * Other-MaskLayout
;;    * Other-Symbolic
;;    * Pcell
;;    * Power IR/EM
;;    * Spectre-Layout
;;    * Spectre-MaskLayout
;;    * Spectre-Symbolic
;;    * UltraSim-Layout
;;    * UltraSim-MaskLayout
;;    * UltraSim-Symbolic
;;    * VLS-GXL
;;    * Virtuoso CE
;;    * Virtuoso XL
;;    * adegxl-maskLayout
;;    * adexl-maskLayout
;;    * parasitics-MaskLayout
;;    * sip-layout
;;-----------------------------------------------------------------------------
hiSetBindKeys( "Layout" list(
    list("<DrawThru1>"    "leSelBoxOrStretch()"    "geSingleSelectBox()")
    list("<DrawThru2>"    ""    "_cmdOptionDrawThru2()")
    list("<DrawThru3>"    "hiZoomIn()"    "hiZoomIn()")
    list("<Key>'"    "hiUpdateMagOptions()")
    list("<Key>,"    ""    "leSetEnv(\"orientation\" \"MY\")")
    list("<Key>."    ""    "leSetEnv(\"orientation\" \"MX\")")
    list("<Key>A"    "leHiAlign()")
    list("<Key>B"    "leReturnToLevel()")
    list("<Key>BackSpace"    "deletePoint()"    "deletePoint()")
    list("<Key>C"    "leHiCopy()")
    list("<Key>D"    "leHiDescend( hiGetCurrentWindow() \"read\" )")
    list("<Key>Delete"    "myDelete()"    "myDelete()")
    list("<Key>Down"    "geScroll(nil \"s\"    nil)")
    list("<Key>E"    "leHiEditDisplayOptions()")
    list("<Key>Escape"    ""    "cancelEnterFun()")
    list("<Key>F"    "hiZoomAbsoluteScale(hiGetCurrentWindow() 0.9)")
    list("<Key>F1"    "hiHelp('window deGetAppInfo(deGetEditViewType(hiGetCurrentWindow()))->appName)")
    list("<Key>F10"    "nclToggleCAEMode()")
    list("<Key>F11"    "deToggleAssistants()")
    list("<Key>F2"    "geSave()")
    list("<Key>F3"    "hiToggleEnterForm()"    "hiToggleEnterForm()")
    list("<Key>F4"    "geTogglePartialSelect()")
    list("<Key>F5"    "geToggleAreaSelectOption()")
    list("<Key>F6"    "leToggleMaintainConnections()")
    list("<Key>F7"    "leHiEditDRDRuleOptions()")
    list("<Key>F9"    "geToggleFilterSize()")
    list("<Key>G"    "leToggleGravity()")
    list("<Key>H"    "leSetFormSnapMode(\"orthogonal\")")
    list("<Key>I"    "leHiCreateInst()")
    list("<Key>J"    "_leApplyDeltaCB(hiGetCurrentWindow())")
    list("<Key>K"    "leHiCreateRuler()" "leToggleSmartSnap()")
    list("<Key>KP_0"    "legRpDelta = 0.001" "")
    list("<Key>KP_1"    "legRpDelta = 0.005" "")
    list("<Key>KP_2"    "leMoveCursor(0 -legRpDelta)" "")
    list("<Key>KP_3"    "legRpDelta = 0.01" "")
    list("<Key>KP_4"    "leMoveCursor(-legRpDelta 0)" "")
    list("<Key>KP_5"    "leMoveCursorToRefPoint()" "")
    list("<Key>KP_6"    "leMoveCursor(legRpDelta 0 )" "")
    list("<Key>KP_7"    "legRpDelta = 0.05" "")
    list("<Key>KP_8"    "leMoveCursor(0 legRpDelta)" "")
    list("<Key>KP_9"    "legRpDelta = 0.1" "")
    list("<Key>KP_Add"    "leHiSetRefPoint()")
    list("<Key>KP_Decimal"    "leSetRefPoint(geGetEditCellView() 0:0)")
    list("<Key>KP_Divide"    "cond((legRpDelta > 0.05 legRpDelta=legRpDelta/2))"    "drdAddTarget()")
    list("<Key>KP_Enter"    "mouseAddPt()"    "mouseAddPt")
    list("<Key>KP_Equal"    "legRpDelta = 0.5")
    list("<Key>KP_Multiply"    "legRpDelta = legRpDelta * 2"    "legRpDelta = legRpDelta*2")
    list("<Key>KP_Subtract"    "leSetRefPointInactive(geGetEditCellView())")
    list("<Key>L"    "leHiCreateLabel(hiGetCurrentWindow() leGetEnv(\"labelMode\"))")
    list("<Key>Left"    "geScroll(nil \"w\"    nil)")
    list("<Key>M"    "leHiMove()")
    list("<Key>N"    "leSetFormSnapMode(\"anyAngle\")")
    list("<Key>O"    "leHiCreateVia()")
    list("<Key>P"    "leHiCreatePath()")
    list("<Key>Q"    "leHiEditProp()")
    list("<Key>R"    "leHiCreateRect()"    "leRotateCB()")
    list("<Key>R11"    "geScroll(nil \"\"    nil)")
    list("<Key>R13"    "geScroll(nil \"sw\"    nil)")
    list("<Key>R15"    "geScroll(nil \"se\"    nil)")
    list("<Key>R4"    "legRpDelta = 0.5")
    list("<Key>R5"    "legRpDelta = 1.0")
    list("<Key>R6"    "legRpDelta = 2.0")
    list("<Key>R7"    "geScroll(nil \"nw\"    nil)")
    list("<Key>R9"    "geScroll(nil \"ne\"    nil)")
    list("<Key>Right"    "geScroll(nil \"e\"    nil)")
    list("<Key>S"    "leHiStretch()")
    list("<Key>T"    "leHiMarkNet()")
    list("<Key>Tab"    "hiPan()")
    list("<Key>U"    "hiUndo()")
    list("<Key>Up"    "geScroll(nil \"n\"    nil)")
    list("<Key>W"    "hiPrevWinView(hiGetCurrentWindow())")
    list("<Key>X"    "leHiEditInPlace()")
    list("<Key>Y"    "leSetFormSnapMode(\"diagonal\")")
    list("<Key>Z"    "hiZoomIn()")
    list("<Key>["    "hiZoomRelativeScale(getCurrentWindow() 0.5)"    "hiZoomRelativeScale(getCurrentWindow() 0.5)")
    list("<Key>]"    "hiZoomRelativeScale(getCurrentWindow() 1.5)"    "hiZoomRelativeScale(getCurrentWindow() 1.5)")
    list("<Key>space"    "leHiAddWireVia(hiGetCurrentWindow())"    "leSpaceBarFunc(hiGetCurrentWindow() t)")
    list("Ctrl Return"    ""    "_geCtrlFinishPt()")
    list("Ctrl Shift<Btn1Down>"    "hiZoomInMagnifier(hiGetCurrentWindow())")
    list("Ctrl Shift<Btn2Down>"    "hiZoomOutMagnifier(hiGetCurrentWindow())")
    list("Ctrl Shift<Btn4Down>"    "_leWireCmdMagnifierOrIncreaseWidth()")
    list("Ctrl Shift<Btn5Down>"    "_leWireCmdMagnifierOrDecreaseWidth()")
    list("Ctrl Shift<Key>D"    "leHiP2P()")
    list("Ctrl Shift<Key>Down"    "hiScaleMagnifier(0.80)")
    list("Ctrl Shift<Key>F"    "leFinishWire()")
    list("Ctrl Shift<Key>G"    "leHiGuidedRouting()")
    list("Ctrl Shift<Key>K"    "leHiClearRulerInHier()")
    list("Ctrl Shift<Key>M"    "geHiDeleteAllMarker()")
    list("Ctrl Shift<Key>N"    "leFinishEntireNet()")
    list("Ctrl Shift<Key>P"    "leDefineInternalPins()")
    list("Ctrl Shift<Key>Q"    "leHiAddWireVia(hiGetCurrentWindow() \"up\")")
    list("Ctrl Shift<Key>S"    "leHiGuidedRouting()")
    list("Ctrl Shift<Key>Up"    "hiScaleMagnifier(1.25)")
    list("Ctrl Shift<Key>W"    "leHiCreateWire()")
    list("Ctrl Shift<Key>X"    "leWECycleControlWire()")
    list("Ctrl Shift<Key>Z"    "leWECycleControlWire()")
    list("Ctrl Shift<Key>space"    "(leWENoSnap)"    "leSpaceBarFunc(hiGetCurrentWindow() \"ctrlShift\")")
    list("Ctrl<Btn1Down>"    "mouseSubSelectPt()"    "mouseSubSelectPt()")
    list("Ctrl<Btn1Down>(2)"    ""    "_geCtrlFinishPt()")
    list("Ctrl<Btn2Down>"    ""    "cmdCtrlOption()")
    list("None<Btn4Down>"    "hiZoomInAtMouse()"    "hiZoomInAtMouse()")
    list("None<Btn5Down>"    "hiZoomOutAtMouse()"    "hiZoomOutAtMouse()")
    list("Ctrl<DrawThru1>"    "geSubSelectBox()"    "geSubSelectBox()")
    list("Ctrl<Key>A"    "geSelectAllFig()")
    list("Ctrl<Key>B"    "leBalloonToggleOnOff()")
    list("Ctrl<Key>D"    "geDeselectAllFig()")
    list("Ctrl<Key>Down"    "geScroll(nil \"s\"    t)")
    list("Ctrl<Key>E"    "leToggleDrdMode()")
    list("Ctrl<Key>F"    "hiGetCurrentWindow()->stopLevel = 0")
    list("Ctrl<Key>F11"    "deToggleToolbars()")
    list("Ctrl<Key>G"    "geZoomToGrid(hiGetCurrentWindow())")
    list("Ctrl<Key>H"    "geDSAFreeze(hiGetCurrentWindow()  hiGetPoint(hiGetCurrentWindow()))")
    list("Ctrl<Key>I"    "leBalloonCycleThru()")
    list("Ctrl<Key>J"    "leHiFlip()")
    list("Ctrl<Key>K"    "leToggleKeepFirstName()")
    list("Ctrl<Key>KP_Enter"    ""    "_geCtrlAddPt()")
    list("Ctrl<Key>L"    "lxProbeRemoveAll()")
    list("Ctrl<Key>Left"    "_leRotateOrFlip(\"R90\")    t)")
    list("Ctrl<Key>M"    "lxHiSwapComps()")
    list("Ctrl<Key>N"    "leSetFormSnapMode(\"L90XFirst\")")
    list("Ctrl<Key>O"    "geSelectViaPile()")
    list("Ctrl<Key>P"    "leHiCreateChoiceOfPin()")
    list("Ctrl<Key>R"    "hiRedraw()")
    list("Ctrl<Key>R11"    "geScroll(nil \"\"    t)")
    list("Ctrl<Key>R13"    "geScroll(nil \"sw\"    t)")
    list("Ctrl<Key>R15"    "geScroll(nil \"se\"    t)")
    list("Ctrl<Key>R7"    "geScroll(nil \"nw\"    t)")
    list("Ctrl<Key>R9"    "geScroll(nil \"ne\"    t)")
    list("Ctrl<Key>Right"    "_leRotateOrFlip(\"R270\")    t)")
    list("Ctrl<Key>S"    "leHiSplit()")
    list("Ctrl<Key>T"    "_leUnmarkNetAllCB()")
    list("Ctrl<Key>Tab"    "hiLowerWindow(hiGetCurrentWindow())")
    list("Ctrl<Key>Up"    "geScroll(nil \"n\"    t)")
    list("Ctrl<Key>W"    "CCScloseWindow()")
    list("Ctrl<Key>X"    "leHiFlatten()")
    list("Ctrl<Key>Y"    "geCycleSelectNext()")
    list("Ctrl<Key>Z"    "hiZoomRelativeScale(hiGetCurrentWindow() 2.0)")
    list("Ctrl<Key>space"    "(leWECycleSnap)"    "leSpaceBarFunc(hiGetCurrentWindow() \"cancel\")")
    list("None<Btn1Down>"    "_leiLMBPress() mouseSingleSelectPt() _leiLMBPress() _leiLMBPress() _leiLMBPress() _leiLMBPress() _leiLMBPress()"    "mouseAddPt(t)")
    list("None<Btn1Down>(2)"    "leDoubleClick()"    "mouseApplyOrFinishPoint()")
    list("None<Btn2Down>"    "hiRepeat()"    "cmdOption()")
    list("None<Btn3Down>"    "_lxHiMousePopUp()"    "_lxHiMousePopUp()")
    list("None<Btn3Down>(2)"    "leHiEditProp()"    "hiToggleEnterForm()")
    list("Ctrl<Btn4Down>"    "geScroll(nil \"n\" nil)")
    list("Ctrl<Btn5Down>"    "geScroll(nil \"s\" nil)")
    list("Return"    ""    "mouseApplyOrFinishPoint()")
    list("Shift Return"    ""    "_geShiftFinishPt()")
    list("Shift<Btn1Down>"    "mouseAddSelectPt()"    "mouseAddSelectPt()")
    list("Shift<Btn1Down>(2)"    ""    "_geShiftFinishPt()")
    list("Shift<Btn2Down>"    ""    "cmdShiftOption()")
    list("Shift<Btn4Down>"    "geScroll(nil \"w\" nil)")
    list("Shift<Btn5Down>"    "geScroll(nil \"e\" nil)")
    list("Shift<DrawThru1>"    "geAddSelectBox()"    "geAddSelectBox()")
    list("Shift<DrawThru3>"    "hiZoomOut()"    "hiZoomOut()")
    list("Shift<Key>B"    "leReturn()")
    list("Shift<Key>C"    "leHiChop()")
    list("Shift<Key>D"    "geSubSelectBox()")
    list("Shift<Key>Down"    "leMoveCursor(0    -legRpDelta)")
    list("Shift<Key>E"    "leHiEditEditorOptions()")
    list("Shift<Key>F"    "hiGetCurrentWindow()->stopLevel = dbGetMaxHierDepth()")
    list("Shift<Key>F11"    "deToggleToolbars() deToggleAssistants()")
    list("Shift<Key>F4"    "geToggleAreaSelectOption()")
    list("Shift<Key>F5"    "leFullSelectFigOfSelSet()")
    list("Shift<Key>G"    "leHiCreateGuardRing()")
    list("Shift<Key>H"    "lxShowHideIncompleteNets()"    "_leGetCoordinateForm()")
    list("Shift<Key>I"    "leHiGuidedRoutingReverseEnvelope(hiGetCurrentWindow())")
    list("Shift<Key>K"    "leHiClearRuler()")
    list("Shift<Key>KP_Enter"    ""    "_geShiftAddPt()")
    list("Shift<Key>L"    "geSingleSelectBox()")
    list("Shift<Key>Left"    "leMoveCursor(-legRpDelta    0)")
    list("Shift<Key>M"    "leHiMerge()")
    list("Shift<Key>N"    "leSetFormSnapMode(\"orthogonal\")")
    list("Shift<Key>R"    "leHiRotate()")
    list("Shift<Key>P"    "leHiCreateBus()")
    list("Shift<Key>Q"    "leEditDesignProperties()")
    list("Shift<Key>O"    "leHiReShape()")
    list("Shift<Key>R11"    "leMoveCursorToRefPoint()")
    list("Shift<Key>R13"    "leMoveCursor(-legRpDelta -legRpDelta)")
    list("Shift<Key>R15"    "leMoveCursor( legRpDelta -legRpDelta)")
    list("Shift<Key>R7"    "leMoveCursor(-legRpDelta  legRpDelta)")
    list("Shift<Key>R9"    "leMoveCursor( legRpDelta  legRpDelta)")
    list("Shift<Key>Right"    "leMoveCursor( legRpDelta    0)")
    list("Shift<Key>S"    "leHiSearch()")
    list("Shift<Key>T"    "leHiUnmarkNet()")
    list("Shift<Key>U"    "hiRedo()")
    list("Shift<Key>Up"    "leMoveCursor(    0  legRpDelta)")
    list("Shift<Key>W"    "hiNextWinView(hiGetCurrentWindow())")
    list("Shift<Key>X"    "leHiDescend()")
    list("Shift<Key>Y"    "leHiPaste()")
    list("Shift<Key>Z"    "hiZoomRelativeScale(hiGetCurrentWindow() 0.5)")
    list("Shift<Key>space"    ""    "leSpaceBarFunc(hiGetCurrentWindow() t t)")
    list("ShiftCtrl<Key>H"    "lxToggleShowAllIncompleteNets()")

    list("Shift<Key>V"    "leSetAllLayerVisible(t)    hiRedraw()")
    list("Ctrl<Key>V"    "leiMouseSetEntryLayer(1) leSetAllLayerVisible(nil)  hiRedraw()")

) ;;list
) ;; hiSetBindKeys
;;-----------------------------------------------------------------------------
