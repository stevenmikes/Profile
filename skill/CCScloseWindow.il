procedure( CCScloseWindow()
dbReopen(geGetEditCellView() "r")
leCloseWindow()
)
